* R9 Coin cell under a radio burst - battery designs (expert EXP-BAT-04)
* Cell = ideal source + internal resistance. RINT rises with age and cold
* (use the cell datasheet; tens of ohms fresh, 100+ ohms near end of life or cold).
* Measure: min V(vbat) during the 3 ms pulse; compare with the MCU brown-out level.
* Run with CBUF present and with CBUF removed; repeat with RINT=100 VCELL=2.8.
* Expected (ee_calc.py pulse-sag): no buffer 2.70 V; 100 uF 2.77 V (fresh cell).
.param VCELL=3.0 RINT=20 CBUF=100u ESR=0.1
VCELL cell 0 DC {VCELL}
RINT cell vbat {RINT}
CBUF vbat nb {CBUF}
RESR nb 0 {ESR}
ISLEEP vbat 0 DC 5u
ITX vbat 0 PULSE(0 15m 10m 10u 10u 3m 1)
* Suggested analysis: .tran 10u 20m
.end
